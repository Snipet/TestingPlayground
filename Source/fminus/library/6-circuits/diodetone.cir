* diodetone.cir: a passive diode clipper, then a tone pot into a low-pass: an analog circuit as a module.
*
* R1 into C1 with two 1N914s across it, back to back (they clip at about 0.6 V), then R2 and a 25k tone rheostat into
* C2, a low-pass that turns from bright to dark. A netlist: FMinus's circuit compiler makes it a module (the
* playground's README, "Circuits"), the research report's example 1.
*
*   DiodeTone clip;                a field of your module (the program has #include "diodetone.cir")
*   clip.init(rate);               in init: the host's rate, every state at rest, the pot at its default
*   clip.set(tone);                0 (dark) to 1 (bright): on the 16-sample grid, before the first sample and every
*                                  16 samples after (a dial's glide reaches it there)
*   y = clip.tick(x);              one sample: x volts in (1.0 = 1 V), y volts out: it clips from about 0.6 V; a
*                                  line level of 1 to 4.5 V drives it hard
*   clip.clear();                  silence
*
* Configuration (fixed, so it never changes as it plays): 4x IIR halfbands, omega3 + 2 Newton steps, what
* fminus diodetone.cir --self-test chose without these three lines: "the self-test chose .oversample 4, .adaa off,
* .solver omega(2)" (T1 -93.1, T2 -79.0, T3 0.10 dB on the report's stress matrix). About 3.5 host samples of delay.
.title DiodeTone
.input  u    in   scale=1          ; 1.0 = 1 V into R1
.output vout b
.pot    tone 0.5 lin               ; 1: bright (0 ohm), 0: dark (25k)
.oversample 4 iir blocks=auto
.adaa off
.solver omega(2)
.target solver=-60dB alias=-60dB level=4.5V freq=3k
R1     in a  2.2k
C1     a  0  10n
D1     a  0  1N914
D2     0  a  1N914
R2     a  c  470
Ptone  c  b  25k {1 - tone}        ; a rheostat
C2     b  0  22n
.model 1N914 D(IS=2.52n N=1.752)
.end
